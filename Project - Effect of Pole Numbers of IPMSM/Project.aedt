# Ansys Electronics Desktop project, version 2018.1
materials:
  vacuum: permittivity=1
  copper: permeability=0.999991 conductivity=58000000
  N36Z_20: permeability=1.03 magnetic_coercivity{Magnitude=-920000A_per_meter DirComp1=1 DirComp2=0 DirComp3=0}
  M19_29G: core_loss_curve{50Hz (0, 0) (0.1, 0.03) (0.2, 0.07) (0.3, 0.13) (0.4, 0.22) (0.5, 0.31) (0.6, 0.43) (0.7, 0.54) (0.8, 0.68) (0.9, 0.83) (1, 1.01) (1.1, 1.2) (1.2, 1.42) (1.3, 1.7) (1.4, 2.12) (1.5, 2.47) (1.6, 2.8) (1.7, 3.05) (1.8, 3.25)} core_loss_curve{100Hz (0, 0) (0.1, 0.04) (0.2, 0.16) (0.3, 0.34) (0.4, 0.55) (0.5, 0.8) (0.6, 1.08) (0.7, 1.38) (0.8, 1.73) (0.9, 2.1) (1, 2.51) (1.1, 2.98) (1.2, 3.51) (1.3, 4.15) (1.4, 4.97) (1.5, 5.92)} core_loss_curve{200Hz (0, 0) (0.1, 0.09) (0.2, 0.37) (0.3, 0.79) (0.4, 1.31) (0.5, 1.91) (0.6, 2.61) (0.7, 3.39) (0.8, 4.26) (0.9, 5.23) (1, 6.3) (1.1, 7.51) (1.2, 8.88) (1.3, 10.5) (1.4, 12.5) (1.5, 14.9)} core_loss_curve{400Hz (0, 0) (0.1, 0.21) (0.2, 0.92) (0.3, 1.99) (0.4, 3.33) (0.5, 4.94) (0.6, 6.84) (0.7, 9) (0.8, 11.4) (0.9, 14.2) (1, 17.3) (1.1, 20.9) (1.2, 24.9) (1.3, 29.5) (1.4, 35.4) (1.5, 41.8)} core_loss_curve{1000Hz (0, 0) (0.1, 0.99) (0.2, 3.67) (0.3, 7.63) (0.4, 12.7) (0.5, 18.9) (0.6, 26.4) (0.7, 35.4) (0.8, 46) (0.9, 58.4) (1, 73) (1.1, 90.1)} permeability{BType=normal HUnit=A_per_meter BUnit=tesla curve (0, 0) (22.28, 0.05) (25.46, 0.1) (31.83, 0.15) (47.74, 0.36) (63.66, 0.54) (79.57, 0.65) (159.15, 0.99) (318.3, 1.2) (477.46, 1.28) (636.61, 1.33) (795.77, 1.36) (1591.5, 1.44) (3183, 1.52) (4774.6, 1.58) (6366.1, 1.63) (7957.7, 1.67) (15915, 1.8) (31830, 1.9) (111407, 2) (190984, 2.1) (350138, 2.3) (509252, 2.5) (560177.2, 2.563994494) (1527756, 3.779889874)} core_loss_type="Electrical Steel" core_loss_kh=0.023403667 core_loss_kc=4.9067657e-05 core_loss_ke=3.4328178e-05

design 1_Pole_Number_6 (Maxwell 2D, Transient, XY geometry, model units mm)
options: ModelDepth=83.82mm Multiplier=1
variables:
  pole_num = 6
  slot_num = 6*pole_num
  Speed_rpm = 1500
  Omega = 360*Speed_rpm*pole_pair/60
  Thet_deg = 45
  Thet = Thet_deg*pi/180
  pole_pair = pole_num/2
  Imax = 400A
  Omega_rad = Omega*pi/180
  Thet_init = 60deg
  ty = 19.07mm*8/pole_num
  ty_rotor = 7.28mm*8/pole_num
  width_mag = 32mm
  num_turn = 9*8/pole_num
geometry:
  Stator [M19_29G] = user_primitive(RMxprt/SlotCore.dll, DiaGap=161.9mm, DiaYoke=231.1mm+2*ty, Length=0mm, Skew=0deg, Slots=6*pole_num, SlotType=2, Hs0=1.03mm, Hs01=0mm, Hs1=0mm, Hs2=29.5mm, Bs0=1.93mm, Bs1=5mm*8/pole_num, Bs2=8mm*8/pole_num, Rs=5mm, FilletType=0, HalfSlot=0, SegAngle=0deg, LenRegion=200mm, InfoCore=0)
  Rotor [M19_29G] = user_primitive(RMxprt/IPMCore.dll, DiaGap=160.4mm, DiaYoke=125.2mm-2*ty_rotor, Length=0mm, Poles=pole_num, PoleType=3, D1=157.44mm, O1=0mm, O2=ty_rotor, B1=4.7mm, Rib=14mm, HRib=3mm, DminMag=0.5mm, ThickMag=6.48mm, WidthMag=width_mag, LenRegion=200mm, InfoCore=0)
  Magnet_1 [N36Z_20, oriented by FaceCS2] = user_primitive(RMxprt/IPMCore.dll, DiaGap=160.4mm, DiaYoke=110.64mm, Length=0mm, Poles=pole_num, PoleType=3, D1=157.44mm, O1=0mm, O2=7.28mm, B1=4.7mm, Rib=14mm, HRib=3mm, DminMag=0.5mm, ThickMag=6.48mm, WidthMag=width_mag, LenRegion=200mm, InfoCore=1)
  PhaseA [copper] = user_primitive(RMxprt/LapCoil.dll, DiaGap=161.9mm, DiaYoke=269.24mm, Length=0mm, Skew=0deg, Slots=6*pole_num, SlotType=2, Hs0=1.28mm, Hs1=0.1mm, Hs2=29.7mm, Bs0=2.11mm, Bs1=3.14mm*8/pole_num, Bs2=5.65mm*8/pole_num, Rs=2.5mm, FilletType=0, Layers=1, CoilPitch=5, EndExt=5mm, SpanExt=18mm, BendAngle=0deg, SegAngle=10deg, LenRegion=200mm, InfoCoil=1)
  [Magnet_1, Rotor].rotate(axis=Z, angle=30deg)
  Region [vacuum] = circle(normal=Z, centre=(0mm, 0mm, 0mm), radius=184.39089mm)
  Magnet_11 [N36Z_20, oriented by FaceCS12], Magnet_7 [N36Z_20, oriented by FaceCS8], Magnet_5 [N36Z_20, oriented by FaceCS6], Magnet_10 [N36Z_20, oriented by FaceCS11], Magnet [N36Z_20, oriented by FaceCS1], Magnet_9 [N36Z_20, oriented by FaceCS10], Magnet_3 [N36Z_20, oriented by FaceCS4], Magnet_6 [N36Z_20, oriented by FaceCS7], Magnet_2 [N36Z_20, oriented by FaceCS3], Magnet_8 [N36Z_20, oriented by FaceCS9], Magnet_4 [N36Z_20, oriented by FaceCS5] = Magnet_1.separate_bodies()
  Band [vacuum] = circle(normal=Z, centre=(0mm, 0mm, 0mm), radius=80.575mm)
  Band_in [vacuum] = circle(normal=Z, centre=(0mm, 0mm, 0mm), radius=80.4mm)
  Rotor2 [M19_29G] = circle(normal=Z, centre=(0mm, 0mm, 0mm), radius=80.2mm)
  Band2 = circle(normal=Z, centre=(0mm, 0mm, 0mm), radius=78.72mm)
  Rotor3 [M19_29G] = circle(normal=Z, centre=(0mm, 0mm, 0mm), radius=79.46mm)
  Band4 = circle(normal=Z, centre=(0mm, 0mm, 0mm), radius=78.72mm)
  Rotor2.subtract(Band2)
  Rotor3.subtract(Band4)
  PhaseC, PhaseB [copper] = PhaseA.duplicate_around_axis(axis=Z, angle=360deg/slot_num*2, total=3)
  PhaseA_1..PhaseA_5 [copper] = PhaseA.duplicate_around_axis(axis=Z, angle=360deg/pole_num, total=6)
  PhaseC_1..PhaseC_5 [copper] = PhaseC.duplicate_around_axis(axis=Z, angle=360deg/pole_num, total=6)
  PhaseB_1..PhaseB_5 [copper] = PhaseB.duplicate_around_axis(axis=Z, angle=360deg/pole_num, total=6)
  coordinate_system FaceCS1 = face of Magnet: Origin=Magnet_1.vertex(22 of 48) FaceID=Magnet_1.face(6 of 12) AxisPosn=Magnet_1.vertex(23 of 48) WhichAxis=X
  coordinate_system FaceCS2 = face of Magnet_1: Origin=Magnet_1.vertex(2 of 48) FaceID=Magnet_1.face(1 of 12) AxisPosn=Magnet_1.vertex(3 of 48) WhichAxis=X
  coordinate_system FaceCS3 = face of Magnet_2: Origin=Magnet_1.vertex(39 of 48) FaceID=Magnet_1.face(10 of 12) AxisPosn=Magnet_1.vertex(38 of 48) WhichAxis=X
  coordinate_system FaceCS4 = face of Magnet_3: Origin=Magnet_1.vertex(31 of 48) FaceID=Magnet_1.face(8 of 12) AxisPosn=Magnet_1.vertex(30 of 48) WhichAxis=X
  coordinate_system FaceCS5 = face of Magnet_4: Origin=Magnet_1.vertex(47 of 48) FaceID=Magnet_1.face(12 of 12) AxisPosn=Magnet_1.vertex(46 of 48) WhichAxis=X
  coordinate_system FaceCS6 = face of Magnet_5: Origin=Magnet_1.vertex(13 of 48) FaceID=Magnet_1.face(4 of 12) AxisPosn=Magnet_1.vertex(16 of 48) WhichAxis=X
  coordinate_system FaceCS7 = face of Magnet_6: Origin=Magnet_1.vertex(36 of 48) FaceID=Magnet_1.face(9 of 12) AxisPosn=Magnet_1.vertex(33 of 48) WhichAxis=X
  coordinate_system FaceCS8 = face of Magnet_7: Origin=Magnet_1.vertex(10 of 48) FaceID=Magnet_1.face(3 of 12) AxisPosn=Magnet_1.vertex(11 of 48) WhichAxis=X
  coordinate_system FaceCS9 = face of Magnet_8: Origin=Magnet_1.vertex(44 of 48) FaceID=Magnet_1.face(11 of 12) AxisPosn=Magnet_1.vertex(41 of 48) WhichAxis=X
  coordinate_system FaceCS10 = face of Magnet_9: Origin=Magnet_1.vertex(28 of 48) FaceID=Magnet_1.face(7 of 12) AxisPosn=Magnet_1.vertex(25 of 48) WhichAxis=X
  coordinate_system FaceCS11 = face of Magnet_10: Origin=Magnet_1.vertex(17 of 48) FaceID=Magnet_1.face(5 of 12) AxisPosn=Magnet_1.vertex(20 of 48) WhichAxis=X
  coordinate_system FaceCS12 = face of Magnet_11: Origin=Magnet_1.vertex(5 of 48) FaceID=Magnet_1.face(2 of 12) AxisPosn=Magnet_1.vertex(8 of 48) WhichAxis=X
  PhaseA_Separate1 [copper] = PhaseA.separate_bodies()
  PhaseA_1_Separate1 [copper] = PhaseA_1.separate_bodies()
  PhaseA_2_Separate1 [copper] = PhaseA_2.separate_bodies()
  PhaseA_3_Separate1 [copper] = PhaseA_3.separate_bodies()
  PhaseA_4_Separate1 [copper] = PhaseA_4.separate_bodies()
  PhaseA_5_Separate1 [copper] = PhaseA_5.separate_bodies()
  PhaseB_Separate1 [copper] = PhaseB.separate_bodies()
  PhaseB_1_Separate1 [copper] = PhaseB_1.separate_bodies()
  PhaseB_2_Separate1 [copper] = PhaseB_2.separate_bodies()
  PhaseB_3_Separate1 [copper] = PhaseB_3.separate_bodies()
  PhaseB_4_Separate1 [copper] = PhaseB_4.separate_bodies()
  PhaseB_5_Separate1 [copper] = PhaseB_5.separate_bodies()
  PhaseC_Separate1 [copper] = PhaseC.separate_bodies()
  PhaseC_1_Separate1 [copper] = PhaseC_1.separate_bodies()
  PhaseC_2_Separate1 [copper] = PhaseC_2.separate_bodies()
  PhaseC_3_Separate1 [copper] = PhaseC_3.separate_bodies()
  PhaseC_4_Separate1 [copper] = PhaseC_4.separate_bodies()
  PhaseC_5_Separate1 [copper] = PhaseC_5.separate_bodies()
motion:
  MotionSetup1: Band Move_Type=Rotate Coordinate_System=Global Axis=Z Is_Positive=true InitPos=Thet_init Angular_Velocity=speed_rpm*pi/30 Objects=Band
  Moving1: Moving Objects=[Rotor, Magnet_1, Magnet_11, Magnet_7, Magnet_5, Magnet_10, Magnet, Magnet_9, Magnet_3, Magnet_6, Magnet_2, Magnet_8, Magnet_4, Band_in, Rotor2, Rotor3]
boundaries and excitations:
  Zero_Flux: Vector Potential Edges=Region.edge(1 of 1) Value=0
  PhaseA_5_Separate1: Coil Objects=PhaseA_5_Separate1 Conductor_number=num_turn Winding=Phase_A PolarityType=Positive
  PhaseA: Coil Objects=PhaseA Conductor_number=num_turn Winding=Phase_A PolarityType=Positive
  PhaseB_5_Separate1: Coil Objects=PhaseB_5_Separate1 Conductor_number=num_turn Winding=Phase_B PolarityType=Positive
  PhaseB: Coil Objects=PhaseB Conductor_number=num_turn Winding=Phase_B PolarityType=Positive
  PhaseC_Separate1: Coil Objects=PhaseC_Separate1 Conductor_number=num_turn Winding=Phase_C PolarityType=Positive
  PhaseC_1: Coil Objects=PhaseC_1 Conductor_number=num_turn Winding=Phase_C PolarityType=Positive
  PhaseA_1_Separate1: Coil Objects=PhaseA_1_Separate1 Conductor_number=num_turn Winding=Phase_A PolarityType=Positive
  PhaseA_2: Coil Objects=PhaseA_2 Conductor_number=num_turn Winding=Phase_A PolarityType=Positive
  PhaseB_1_Separate1: Coil Objects=PhaseB_1_Separate1 Conductor_number=num_turn Winding=Phase_B PolarityType=Positive
  PhaseB_2: Coil Objects=PhaseB_2 Conductor_number=num_turn Winding=Phase_B PolarityType=Positive
  PhaseC_2_Separate1: Coil Objects=PhaseC_2_Separate1 Conductor_number=num_turn Winding=Phase_C PolarityType=Positive
  PhaseC_3: Coil Objects=PhaseC_3 Conductor_number=num_turn Winding=Phase_C PolarityType=Positive
  PhaseA_3_Separate1: Coil Objects=PhaseA_3_Separate1 Conductor_number=num_turn Winding=Phase_A PolarityType=Positive
  PhaseA_4: Coil Objects=PhaseA_4 Conductor_number=num_turn Winding=Phase_A PolarityType=Positive
  PhaseB_3_Separate1: Coil Objects=PhaseB_3_Separate1 Conductor_number=num_turn Winding=Phase_B PolarityType=Positive
  PhaseB_4: Coil Objects=PhaseB_4 Conductor_number=num_turn Winding=Phase_B PolarityType=Positive
  PhaseC_4_Separate1: Coil Objects=PhaseC_4_Separate1 Conductor_number=num_turn Winding=Phase_C PolarityType=Positive
  PhaseC_5: Coil Objects=PhaseC_5 Conductor_number=num_turn Winding=Phase_C PolarityType=Positive
  PhaseC_5_Separate1: Coil Objects=PhaseC_5_Separate1 Conductor_number=num_turn Winding=Phase_C PolarityType=Negative
  PhaseC: Coil Objects=PhaseC Conductor_number=num_turn Winding=Phase_C PolarityType=Negative
  PhaseA_Separate1: Coil Objects=PhaseA_Separate1 Conductor_number=num_turn Winding=Phase_A PolarityType=Negative
  PhaseA_1: Coil Objects=PhaseA_1 Conductor_number=num_turn Winding=Phase_A PolarityType=Negative
  PhaseB_Separate1: Coil Objects=PhaseB_Separate1 Conductor_number=num_turn Winding=Phase_B PolarityType=Negative
  PhaseB_1: Coil Objects=PhaseB_1 Conductor_number=num_turn Winding=Phase_B PolarityType=Negative
  PhaseC_1_Separate1: Coil Objects=PhaseC_1_Separate1 Conductor_number=num_turn Winding=Phase_C PolarityType=Negative
  PhaseC_2: Coil Objects=PhaseC_2 Conductor_number=num_turn Winding=Phase_C PolarityType=Negative
  PhaseA_2_Separate1: Coil Objects=PhaseA_2_Separate1 Conductor_number=num_turn Winding=Phase_A PolarityType=Negative
  PhaseA_3: Coil Objects=PhaseA_3 Conductor_number=num_turn Winding=Phase_A PolarityType=Negative
  PhaseB_2_Separate1: Coil Objects=PhaseB_2_Separate1 Conductor_number=num_turn Winding=Phase_B PolarityType=Negative
  PhaseB_3: Coil Objects=PhaseB_3 Conductor_number=num_turn Winding=Phase_B PolarityType=Negative
  PhaseC_3_Separate1: Coil Objects=PhaseC_3_Separate1 Conductor_number=num_turn Winding=Phase_C PolarityType=Negative
  PhaseC_4: Coil Objects=PhaseC_4 Conductor_number=num_turn Winding=Phase_C PolarityType=Negative
  PhaseA_4_Separate1: Coil Objects=PhaseA_4_Separate1 Conductor_number=num_turn Winding=Phase_A PolarityType=Negative
  PhaseA_5: Coil Objects=PhaseA_5 Conductor_number=num_turn Winding=Phase_A PolarityType=Negative
  PhaseB_4_Separate1: Coil Objects=PhaseB_4_Separate1 Conductor_number=num_turn Winding=Phase_B PolarityType=Negative
  PhaseB_5: Coil Objects=PhaseB_5 Conductor_number=num_turn Winding=Phase_B PolarityType=Negative
  Phase_A: Winding Group Type=Current IsSolid=false Current=Imax*sin(Omega_rad*Time+Thet) ParallelBranchesNum=1
  Phase_B: Winding Group Type=Current IsSolid=false Current=Imax*sin(Omega_rad*Time-2*pi/3+Thet) ParallelBranchesNum=1
  Phase_C: Winding Group Type=Current IsSolid=false Current=Imax*sin(Omega_rad*Time+2*pi/3+Thet) ParallelBranchesNum=1
  core loss on: Stator, Rotor, Rotor2, Rotor3
mesh:
  Coils: LengthBased RefineInside Objects=[PhaseA, PhaseA_1..PhaseA_5, PhaseB, PhaseB_1..PhaseB_5, PhaseC, PhaseC_1..PhaseC_5] MaxLength=4mm
  Magnets: LengthBased RefineInside Objects=[Magnet, Magnet_1..Magnet_11] MaxLength=3mm
  RotorStator: LengthBased RefineInside Objects=[Rotor, Rotor2, Rotor3, Stator] MaxLength=4mm
  initial mesh: MeshMethod=AnsoftTAU
setups:
  Setup1: Transient NonlinearSolverResidual=1e-06 SmoothBHCurve StopTime="(80/3) ms" TimeStep="(2/9) ms" SweepSetupType=LinearStep StartValue=0ns StopValue=13.333ms StepSize=1.333ms InitialTimeStep=0.002s MinTimeStep=0.001s MaxTimeStep=0.003s TimeStepErrTolerance=0.0001
field plots:
  Mag_B1: B over Stator, Rotor, Magnet_1, PhaseA, Magnet_11, Magnet_7, Magnet_5, Magnet_10, Magnet, Magnet_9, Magnet_3, Magnet_6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 on Setup1 : Transient at Time=-1
  Flux_Lines1: A over Stator, Rotor, Magnet_1, PhaseA, Magnet_11, Magnet_7, Magnet_5, Magnet_10, Magnet, Magnet_9, Magnet_3, Magnet_6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 on Setup1 : Transient at Time=-1
  B_Vector1: B over Stator, Rotor, Magnet_1, PhaseA, Magnet_11, Magnet_7, Magnet_5, Magnet_10, Magnet, Magnet_9, Magnet_3, Magnet_6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 on Setup1 : Transient at Time=-1
  Mag_B2: B over Stator on Setup1 : Transient at Time=-1
reports:
  Induced_Voltages: InducedVoltage(Phase_A), InducedVoltage(Phase_B), InducedVoltage(Phase_C) vs Time on Setup1 : Transient
  Torque: Moving1.Torque vs Time on Setup1 : Transient [Thet_deg=all]
  Flux_Linkages: FluxLinkage(Phase_A), FluxLinkage(Phase_B), FluxLinkage(Phase_C) vs Time on Setup1 : Transient; markers m1 at 2.2222222ms
   Plot 1: InputCurrent(Phase_A)*InducedVoltage(Phase_A) vs Time on Setup1 : Transient

design 2_Pole_Number_8 (Maxwell 2D, Transient, XY geometry, model units mm)
options: ModelDepth=83.82mm Multiplier=1
variables:
  pole_num = 8
  slot_num = 6*pole_num
  Speed_rpm = 1500
  Omega = 360*Speed_rpm*pole_pair/60
  Thet_deg = 45
  Thet = Thet_deg*pi/180
  pole_pair = pole_num/2
  Imax = 400A
  Omega_rad = Omega*pi/180
  Thet_init = 37.5deg
  ty = 19.07mm*8/pole_num
  ty_rotor = 7.28mm*8/pole_num
  width_mag = 32mm
  num_turn = 9*8/pole_num
geometry:
  Stator [M19_29G] = user_primitive(RMxprt/SlotCore.dll, DiaGap=161.9mm, DiaYoke=231.1mm+2*ty, Length=0mm, Skew=0deg, Slots=6*pole_num, SlotType=2, Hs0=1.03mm, Hs01=0mm, Hs1=0mm, Hs2=29.5mm, Bs0=1.93mm, Bs1=5mm*8/pole_num, Bs2=8mm*8/pole_num, Rs=5mm, FilletType=0, HalfSlot=0, SegAngle=0deg, LenRegion=200mm, InfoCore=0)
  Rotor [M19_29G] = user_primitive(RMxprt/IPMCore.dll, DiaGap=160.4mm, DiaYoke=125.2mm-2*ty_rotor, Length=0mm, Poles=pole_num, PoleType=3, D1=157.44mm, O1=0mm, O2=ty_rotor, B1=4.7mm, Rib=14mm, HRib=3mm, DminMag=0.5mm, ThickMag=6.48mm, WidthMag=width_mag, LenRegion=200mm, InfoCore=0)
  PhaseA [copper] = user_primitive(RMxprt/LapCoil.dll, DiaGap=161.9mm, DiaYoke=269.24mm, Length=0mm, Skew=0deg, Slots=6*pole_num, SlotType=2, Hs0=1.28mm, Hs1=0.1mm, Hs2=29.7mm, Bs0=2.11mm, Bs1=3.14mm*8/pole_num, Bs2=5.65mm*8/pole_num, Rs=2.5mm, FilletType=0, Layers=1, CoilPitch=5, EndExt=5mm, SpanExt=18mm, BendAngle=0deg, SegAngle=10deg, LenRegion=200mm, InfoCoil=1)
  Rotor.rotate(axis=Z, angle=30deg)
  Region [vacuum] = circle(normal=Z, centre=(0mm, 0mm, 0mm), radius=184.39089mm)
  Band [vacuum] = circle(normal=Z, centre=(0mm, 0mm, 0mm), radius=80.575mm)
  Band_in [vacuum] = circle(normal=Z, centre=(0mm, 0mm, 0mm), radius=80.4mm)
  Rotor2 [M19_29G] = circle(normal=Z, centre=(0mm, 0mm, 0mm), radius=80.2mm)
  Band2 = circle(normal=Z, centre=(0mm, 0mm, 0mm), radius=78.8mm)
  Rotor3 [M19_29G] = circle(normal=Z, centre=(0mm, 0mm, 0mm), radius=79.46mm)
  Band4 = circle(normal=Z, centre=(0mm, 0mm, 0mm), radius=78.8mm)
  Rotor2.subtract(Band2)
  Rotor3.subtract(Band4)
  PhaseC, PhaseB [copper] = PhaseA.duplicate_around_axis(axis=Z, angle=360deg/slot_num*2, total=3)
  PhaseA_1..PhaseA_7 [copper] = PhaseA.duplicate_around_axis(axis=Z, angle=360deg/pole_num, total=8)
  PhaseB_1..PhaseB_7 [copper] = PhaseB.duplicate_around_axis(axis=Z, angle=360deg/pole_num, total=8)
  PhaseC_1..PhaseC_7 [copper] = PhaseC.duplicate_around_axis(axis=Z, angle=360deg/pole_num, total=8)
  Magnet [N36Z_20, oriented by FaceCS1] = user_primitive(RMxprt/IPMCore.dll, DiaGap=160.4mm, DiaYoke=125.2mm-2*ty_rotor, Length=0mm, Poles=pole_num, PoleType=3, D1=157.44mm, O1=0mm, O2=ty_rotor, B1=4.7mm, Rib=14mm, HRib=3mm, DminMag=0.5mm, ThickMag=6.48mm, WidthMag=width_mag, LenRegion=200mm, InfoCore=1)
  Magnet.rotate(axis=Z, angle=30deg)
  Magnet_2 [N36Z_20, oriented by FaceCS3], Magnet_10 [N36Z_20, oriented by FaceCS11], Magnet_1 [N36Z_20, oriented by FaceCS2], Magnet_3 [N36Z_20, oriented by FaceCS4], Magnet_12 [N36Z_20, oriented by FaceCS13], Magnet_15 [N36Z_20, oriented by FaceCS16], Magnet_7 [N36Z_20, oriented by FaceCS8], Magnet_13 [N36Z_20, oriented by FaceCS14], Magnet_14 [N36Z_20, oriented by FaceCS15], Magnet_8 [N36Z_20, oriented by FaceCS9], Magnet_9 [N36Z_20, oriented by FaceCS10], Magnet_4 [N36Z_20, oriented by FaceCS5], Magnet_6 [N36Z_20, oriented by FaceCS7], Magnet_11 [N36Z_20, oriented by FaceCS12], Magnet_5 [N36Z_20, oriented by FaceCS6] = Magnet.separate_bodies()
  coordinate_system FaceCS1 = face of Magnet: Origin=Magnet.vertex(2 of 64) FaceID=Magnet.face(1 of 16) AxisPosn=Magnet.vertex(3 of 64) WhichAxis=X
  coordinate_system FaceCS2 = face of Magnet_1: Origin=Magnet.vertex(13 of 64) FaceID=Magnet.face(4 of 16) AxisPosn=Magnet.vertex(16 of 64) WhichAxis=X
  coordinate_system FaceCS3 = face of Magnet_2: Origin=Magnet.vertex(5 of 64) FaceID=Magnet.face(2 of 16) AxisPosn=Magnet.vertex(8 of 64) WhichAxis=X
  coordinate_system FaceCS4 = face of Magnet_3: Origin=Magnet.vertex(18 of 64) FaceID=Magnet.face(5 of 16) AxisPosn=Magnet.vertex(19 of 64) WhichAxis=X
  coordinate_system FaceCS5 = face of Magnet_4: Origin=Magnet.vertex(52 of 64) FaceID=Magnet.face(13 of 16) AxisPosn=Magnet.vertex(49 of 64) WhichAxis=X
  coordinate_system FaceCS6 = face of Magnet_5: Origin=Magnet.vertex(63 of 64) FaceID=Magnet.face(16 of 16) AxisPosn=Magnet.vertex(62 of 64) WhichAxis=X
  coordinate_system FaceCS7 = face of Magnet_6: Origin=Magnet.vertex(55 of 64) FaceID=Magnet.face(14 of 16) AxisPosn=Magnet.vertex(54 of 64) WhichAxis=X
  coordinate_system FaceCS8 = face of Magnet_7: Origin=Magnet.vertex(30 of 64) FaceID=Magnet.face(8 of 16) AxisPosn=Magnet.vertex(31 of 64) WhichAxis=X
  coordinate_system FaceCS9 = face of Magnet_8: Origin=Magnet.vertex(44 of 64) FaceID=Magnet.face(11 of 16) AxisPosn=Magnet.vertex(41 of 64) WhichAxis=X
  coordinate_system FaceCS10 = face of Magnet_9: Origin=Magnet.vertex(47 of 64) FaceID=Magnet.face(12 of 16) AxisPosn=Magnet.vertex(46 of 64) WhichAxis=X
  coordinate_system FaceCS11 = face of Magnet_10: Origin=Magnet.vertex(10 of 64) FaceID=Magnet.face(3 of 16) AxisPosn=Magnet.vertex(11 of 64) WhichAxis=X
  coordinate_system FaceCS12 = face of Magnet_11: Origin=Magnet.vertex(60 of 64) FaceID=Magnet.face(15 of 16) AxisPosn=Magnet.vertex(57 of 64) WhichAxis=X
  coordinate_system FaceCS13 = face of Magnet_12: Origin=Magnet.vertex(21 of 64) FaceID=Magnet.face(6 of 16) AxisPosn=Magnet.vertex(24 of 64) WhichAxis=X
  coordinate_system FaceCS14 = face of Magnet_13: Origin=Magnet.vertex(36 of 64) FaceID=Magnet.face(9 of 16) AxisPosn=Magnet.vertex(33 of 64) WhichAxis=X
  coordinate_system FaceCS15 = face of Magnet_14: Origin=Magnet.vertex(39 of 64) FaceID=Magnet.face(10 of 16) AxisPosn=Magnet.vertex(38 of 64) WhichAxis=X
  coordinate_system FaceCS16 = face of Magnet_15: Origin=Magnet.vertex(25 of 64) FaceID=Magnet.face(7 of 16) AxisPosn=Magnet.vertex(28 of 64) WhichAxis=X
  PhaseA_Separate1 [copper] = PhaseA.separate_bodies()
  PhaseA_1_Separate1 [copper] = PhaseA_1.separate_bodies()
  PhaseA_2_Separate1 [copper] = PhaseA_2.separate_bodies()
  PhaseA_3_Separate1 [copper] = PhaseA_3.separate_bodies()
  PhaseA_4_Separate1 [copper] = PhaseA_4.separate_bodies()
  PhaseA_5_Separate1 [copper] = PhaseA_5.separate_bodies()
  PhaseA_6_Separate1 [copper] = PhaseA_6.separate_bodies()
  PhaseA_7_Separate1 [copper] = PhaseA_7.separate_bodies()
  PhaseB_Separate1 [copper] = PhaseB.separate_bodies()
  PhaseB_1_Separate1 [copper] = PhaseB_1.separate_bodies()
  PhaseB_2_Separate1 [copper] = PhaseB_2.separate_bodies()
  PhaseB_3_Separate1 [copper] = PhaseB_3.separate_bodies()
  PhaseB_4_Separate1 [copper] = PhaseB_4.separate_bodies()
  PhaseB_5_Separate1 [copper] = PhaseB_5.separate_bodies()
  PhaseB_6_Separate1 [copper] = PhaseB_6.separate_bodies()
  PhaseB_7_Separate1 [copper] = PhaseB_7.separate_bodies()
  PhaseC_Separate1 [copper] = PhaseC.separate_bodies()
  PhaseC_1_Separate1 [copper] = PhaseC_1.separate_bodies()
  PhaseC_2_Separate1 [copper] = PhaseC_2.separate_bodies()
  PhaseC_3_Separate1 [copper] = PhaseC_3.separate_bodies()
  PhaseC_4_Separate1 [copper] = PhaseC_4.separate_bodies()
  PhaseC_5_Separate1 [copper] = PhaseC_5.separate_bodies()
  PhaseC_6_Separate1 [copper] = PhaseC_6.separate_bodies()
  PhaseC_7_Separate1 [copper] = PhaseC_7.separate_bodies()
motion:
  MotionSetup1: Band Move_Type=Rotate Coordinate_System=Global Axis=Z Is_Positive=true InitPos=Thet_init Angular_Velocity=speed_rpm*pi/30 Objects=Band
  Moving1: Moving Objects=[Rotor, Band_in, Rotor2, Rotor3, Magnet, Magnet_2, Magnet_10, Magnet_1, Magnet_3, Magnet_12, Magnet_15, Magnet_7, Magnet_13, Magnet_14, Magnet_8, Magnet_9, Magnet_4, Magnet_6, Magnet_11, Magnet_5]
boundaries and excitations:
  Zero_Flux: Vector Potential Edges=Region.edge(1 of 1) Value=0
  PhaseA: Coil Objects=PhaseA Conductor_number=num_turn Winding=Phase_A PolarityType=Positive
  PhaseA_1_Separate1: Coil Objects=PhaseA_1_Separate1 Conductor_number=num_turn Winding=Phase_A PolarityType=Positive
  PhaseA_2: Coil Objects=PhaseA_2 Conductor_number=num_turn Winding=Phase_A PolarityType=Positive
  PhaseA_3_Separate1: Coil Objects=PhaseA_3_Separate1 Conductor_number=num_turn Winding=Phase_A PolarityType=Positive
  PhaseA_4: Coil Objects=PhaseA_4 Conductor_number=num_turn Winding=Phase_A PolarityType=Positive
  PhaseA_5_Separate1: Coil Objects=PhaseA_5_Separate1 Conductor_number=num_turn Winding=Phase_A PolarityType=Positive
  PhaseA_6: Coil Objects=PhaseA_6 Conductor_number=num_turn Winding=Phase_A PolarityType=Positive
  PhaseA_7_Separate1: Coil Objects=PhaseA_7_Separate1 Conductor_number=num_turn Winding=Phase_A PolarityType=Positive
  PhaseB: Coil Objects=PhaseB Conductor_number=num_turn Winding=Phase_B PolarityType=Positive
  PhaseB_1_Separate1: Coil Objects=PhaseB_1_Separate1 Conductor_number=num_turn Winding=Phase_B PolarityType=Positive
  PhaseB_2: Coil Objects=PhaseB_2 Conductor_number=num_turn Winding=Phase_B PolarityType=Positive
  PhaseB_3_Separate1: Coil Objects=PhaseB_3_Separate1 Conductor_number=num_turn Winding=Phase_B PolarityType=Positive
  PhaseB_4: Coil Objects=PhaseB_4 Conductor_number=num_turn Winding=Phase_B PolarityType=Positive
  PhaseB_5_Separate1: Coil Objects=PhaseB_5_Separate1 Conductor_number=num_turn Winding=Phase_B PolarityType=Positive
  PhaseB_6: Coil Objects=PhaseB_6 Conductor_number=num_turn Winding=Phase_B PolarityType=Positive
  PhaseB_7_Separate1: Coil Objects=PhaseB_7_Separate1 Conductor_number=num_turn Winding=Phase_B PolarityType=Positive
  PhaseC_1: Coil Objects=PhaseC_1 Conductor_number=num_turn Winding=Phase_C PolarityType=Positive
  PhaseC_2_Separate1: Coil Objects=PhaseC_2_Separate1 Conductor_number=num_turn Winding=Phase_C PolarityType=Positive
  PhaseC_3: Coil Objects=PhaseC_3 Conductor_number=num_turn Winding=Phase_C PolarityType=Positive
  PhaseC_4_Separate1: Coil Objects=PhaseC_4_Separate1 Conductor_number=num_turn Winding=Phase_C PolarityType=Positive
  PhaseC_5: Coil Objects=PhaseC_5 Conductor_number=num_turn Winding=Phase_C PolarityType=Positive
  PhaseC_6_Separate1: Coil Objects=PhaseC_6_Separate1 Conductor_number=num_turn Winding=Phase_C PolarityType=Positive
  PhaseC_7: Coil Objects=PhaseC_7 Conductor_number=num_turn Winding=Phase_C PolarityType=Positive
  PhaseC_Separate1: Coil Objects=PhaseC_Separate1 Conductor_number=num_turn Winding=Phase_C PolarityType=Positive
  PhaseC_7_Separate1: Coil Objects=PhaseC_7_Separate1 Conductor_number=num_turn Winding=Phase_C PolarityType=Negative
  PhaseC: Coil Objects=PhaseC Conductor_number=num_turn Winding=Phase_C PolarityType=Negative
  PhaseA_Separate1: Coil Objects=PhaseA_Separate1 Conductor_number=num_turn Winding=Phase_A PolarityType=Negative
  PhaseA_1: Coil Objects=PhaseA_1 Conductor_number=num_turn Winding=Phase_A PolarityType=Negative
  PhaseB_Separate1: Coil Objects=PhaseB_Separate1 Conductor_number=num_turn Winding=Phase_B PolarityType=Negative
  PhaseB_1: Coil Objects=PhaseB_1 Conductor_number=num_turn Winding=Phase_B PolarityType=Negative
  PhaseC_1_Separate1: Coil Objects=PhaseC_1_Separate1 Conductor_number=num_turn Winding=Phase_C PolarityType=Negative
  PhaseC_2: Coil Objects=PhaseC_2 Conductor_number=num_turn Winding=Phase_C PolarityType=Negative
  PhaseA_2_Separate1: Coil Objects=PhaseA_2_Separate1 Conductor_number=num_turn Winding=Phase_A PolarityType=Negative
  PhaseA_3: Coil Objects=PhaseA_3 Conductor_number=num_turn Winding=Phase_A PolarityType=Negative
  PhaseB_2_Separate1: Coil Objects=PhaseB_2_Separate1 Conductor_number=num_turn Winding=Phase_B PolarityType=Negative
  PhaseB_3: Coil Objects=PhaseB_3 Conductor_number=num_turn Winding=Phase_B PolarityType=Negative
  PhaseC_3_Separate1: Coil Objects=PhaseC_3_Separate1 Conductor_number=num_turn Winding=Phase_C PolarityType=Negative
  PhaseC_4: Coil Objects=PhaseC_4 Conductor_number=num_turn Winding=Phase_C PolarityType=Negative
  PhaseA_4_Separate1: Coil Objects=PhaseA_4_Separate1 Conductor_number=num_turn Winding=Phase_A PolarityType=Negative
  PhaseA_5: Coil Objects=PhaseA_5 Conductor_number=num_turn Winding=Phase_A PolarityType=Negative
  PhaseB_4_Separate1: Coil Objects=PhaseB_4_Separate1 Conductor_number=num_turn Winding=Phase_B PolarityType=Negative
  PhaseB_5: Coil Objects=PhaseB_5 Conductor_number=num_turn Winding=Phase_B PolarityType=Negative
  PhaseC_5_Separate1: Coil Objects=PhaseC_5_Separate1 Conductor_number=num_turn Winding=Phase_C PolarityType=Negative
  PhaseC_6: Coil Objects=PhaseC_6 Conductor_number=num_turn Winding=Phase_C PolarityType=Negative
  PhaseA_6_Separate1: Coil Objects=PhaseA_6_Separate1 Conductor_number=num_turn Winding=Phase_A PolarityType=Negative
  PhaseA_7: Coil Objects=PhaseA_7 Conductor_number=num_turn Winding=Phase_A PolarityType=Negative
  PhaseB_6_Separate1: Coil Objects=PhaseB_6_Separate1 Conductor_number=num_turn Winding=Phase_B PolarityType=Negative
  PhaseB_7: Coil Objects=PhaseB_7 Conductor_number=num_turn Winding=Phase_B PolarityType=Negative
  Phase_A: Winding Group Type=Current IsSolid=false Current=Imax*sin(Omega_rad*Time+Thet) ParallelBranchesNum=1
  Phase_B: Winding Group Type=Current IsSolid=false Current=Imax*sin(Omega_rad*Time-2*pi/3+Thet) ParallelBranchesNum=1
  Phase_C: Winding Group Type=Current IsSolid=false Current=Imax*sin(Omega_rad*Time+2*pi/3+Thet) ParallelBranchesNum=1
  core loss on: Stator, Rotor, Rotor3
mesh:
  Coils: LengthBased RefineInside Objects=[PhaseC_7, PhaseA, PhaseA_1..PhaseA_7, PhaseB, PhaseB_1..PhaseB_7, PhaseC, PhaseC_1..PhaseC_6] MaxLength=4mm
  RotorStator: LengthBased RefineInside Objects=[Rotor, Rotor3, Stator] MaxLength=4mm
  Length1: LengthBased Objects=[Magnet, Magnet_1..Magnet_15] MaxLength=2mm
  initial mesh: MeshMethod=AnsoftTAU
setups:
  Setup1: Transient NonlinearSolverResidual=1e-06 SmoothBHCurve StopTime="(80/3) ms" TimeStep="(2/18) ms" SweepSetupType=LinearStep StartValue=0ns StopValue=10ms StepSize=1ms InitialTimeStep=0.002s MinTimeStep=0.001s MaxTimeStep=0.003s TimeStepErrTolerance=0.0001
reports:
  Torque Plot 1: Moving1.Torque vs Time on Setup1 : Transient
  Induced Voltages: InducedVoltage(Phase_A), InducedVoltage(Phase_B), InducedVoltage(Phase_C) vs Time on Setup1 : Transient
  Flux Linkages: FluxLinkage(Phase_A), FluxLinkage(Phase_B), FluxLinkage(Phase_C) vs Time on Setup1 : Transient
   Plot 1: InputCurrent(Phase_A)*InducedVoltage(Phase_A) vs Time on Setup1 : Transient

design 3_Pole_Number_10 (Maxwell 2D, Transient, XY geometry, model units mm)
options: ModelDepth=83.82mm Multiplier=1
variables:
  pole_num = 10
  slot_num = 6*pole_num
  Speed_rpm = 1500
  Omega = 360*Speed_rpm*pole_pair/60
  Thet_deg = 45
  Thet = Thet_deg*pi/180
  pole_pair = pole_num/2
  Imax = 400A
  Omega_rad = Omega*pi/180
  Thet_init = 24deg
  ty = 19.07mm*8/pole_num
  ty_rotor = 7.28mm*8/pole_num
  width_mag = 32mm
  num_turn = 9*8/pole_num
geometry:
  Stator [M19_29G] = user_primitive(RMxprt/SlotCore.dll, DiaGap=161.9mm, DiaYoke=231.1mm+2*ty, Length=0mm, Skew=0deg, Slots=6*pole_num, SlotType=2, Hs0=1.03mm, Hs01=0mm, Hs1=0mm, Hs2=29.5mm, Bs0=1.93mm, Bs1=5mm*8/pole_num, Bs2=8mm*8/pole_num, Rs=5mm, FilletType=0, HalfSlot=0, SegAngle=0deg, LenRegion=200mm, InfoCore=0)
  Rotor [M19_29G] = user_primitive(RMxprt/IPMCore.dll, DiaGap=160.4mm, DiaYoke=125.2mm-2*ty_rotor, Length=0mm, Poles=pole_num, PoleType=3, D1=157.44mm, O1=0mm, O2=ty_rotor, B1=4.7mm, Rib=14mm, HRib=3mm, DminMag=0.5mm, ThickMag=6.48mm, WidthMag=width_mag, LenRegion=200mm, InfoCore=0)
  PhaseA [copper] = user_primitive(RMxprt/LapCoil.dll, DiaGap=161.9mm, DiaYoke=269.24mm, Length=0mm, Skew=0deg, Slots=6*pole_num, SlotType=2, Hs0=1.28mm, Hs1=0.1mm, Hs2=29.7mm, Bs0=2.11mm, Bs1=3.14mm*8/pole_num, Bs2=5.65mm*8/pole_num, Rs=2.5mm, FilletType=0, Layers=1, CoilPitch=5, EndExt=5mm, SpanExt=18mm, BendAngle=0deg, SegAngle=10deg, LenRegion=200mm, InfoCoil=1)
  Rotor.rotate(axis=Z, angle=30deg)
  Region [vacuum] = circle(normal=Z, centre=(0mm, 0mm, 0mm), radius=184.39089mm)
  Band [vacuum] = circle(normal=Z, centre=(0mm, 0mm, 0mm), radius=80.575mm)
  Band_in [vacuum] = circle(normal=Z, centre=(0mm, 0mm, 0mm), radius=80.4mm)
  Rotor2 [M19_29G] = circle(normal=Z, centre=(0mm, 0mm, 0mm), radius=80.2mm)
  Band2 = circle(normal=Z, centre=(0mm, 0mm, 0mm), radius=78.8mm)
  Rotor3 [M19_29G] = circle(normal=Z, centre=(0mm, 0mm, 0mm), radius=79.46mm)
  Band4 = circle(normal=Z, centre=(0mm, 0mm, 0mm), radius=78.8mm)
  Rotor2.subtract(Band2)
  Rotor3.subtract(Band4)
  PhaseC, PhaseB [copper] = PhaseA.duplicate_around_axis(axis=Z, angle=360deg/slot_num*2, total=3)
  PhaseA_1..PhaseA_9 [copper] = PhaseA.duplicate_around_axis(axis=Z, angle=360deg/pole_num, total=10)
  PhaseB_1..PhaseB_9 [copper] = PhaseB.duplicate_around_axis(axis=Z, angle=360deg/pole_num, total=10)
  PhaseC_1..PhaseC_9 [copper] = PhaseC.duplicate_around_axis(axis=Z, angle=360deg/pole_num, total=10)
  Magnet [N36Z_20, oriented by FaceCS1] = user_primitive(RMxprt/IPMCore.dll, DiaGap=160.4mm, DiaYoke=125.2mm-2*ty_rotor, Length=0mm, Poles=pole_num, PoleType=3, D1=157.44mm, O1=0mm, O2=ty_rotor, B1=4.7mm, Rib=14mm, HRib=3mm, DminMag=0.5mm, ThickMag=6.48mm, WidthMag=width_mag, LenRegion=200mm, InfoCore=1)
  Magnet.rotate(axis=Z, angle=30deg)
  Magnet_3 [N36Z_20, oriented by FaceCS4], Magnet_17 [N36Z_20, oriented by FaceCS18], Magnet_14 [N36Z_20, oriented by FaceCS15], Magnet_15 [N36Z_20, oriented by FaceCS16], Magnet_11 [N36Z_20, oriented by FaceCS12], Magnet_9 [N36Z_20, oriented by FaceCS10], Magnet_1 [N36Z_20, oriented by FaceCS2], Magnet_18 [N36Z_20, oriented by FaceCS19], Magnet_2 [N36Z_20, oriented by FaceCS3], Magnet_19 [N36Z_20, oriented by FaceCS20], Magnet_12 [N36Z_20, oriented by FaceCS13], Magnet_8 [N36Z_20, oriented by FaceCS9], Magnet_16 [N36Z_20, oriented by FaceCS17], Magnet_5 [N36Z_20, oriented by FaceCS6], Magnet_7 [N36Z_20, oriented by FaceCS8], Magnet_13 [N36Z_20, oriented by FaceCS14], Magnet_6 [N36Z_20, oriented by FaceCS7], Magnet_4 [N36Z_20, oriented by FaceCS5], Magnet_10 [N36Z_20, oriented by FaceCS11] = Magnet.separate_bodies()
  coordinate_system FaceCS1 = face of Magnet: Origin=Magnet.vertex(2 of 80) FaceID=Magnet.face(1 of 20) AxisPosn=Magnet.vertex(3 of 80) WhichAxis=X
  coordinate_system FaceCS2 = face of Magnet_1: Origin=Magnet.vertex(29 of 80) FaceID=Magnet.face(8 of 20) AxisPosn=Magnet.vertex(32 of 80) WhichAxis=X
  coordinate_system FaceCS3 = face of Magnet_2: Origin=Magnet.vertex(38 of 80) FaceID=Magnet.face(10 of 20) AxisPosn=Magnet.vertex(39 of 80) WhichAxis=X
  coordinate_system FaceCS4 = face of Magnet_3: Origin=Magnet.vertex(5 of 80) FaceID=Magnet.face(2 of 20) AxisPosn=Magnet.vertex(8 of 80) WhichAxis=X
  coordinate_system FaceCS5 = face of Magnet_4: Origin=Magnet.vertex(76 of 80) FaceID=Magnet.face(19 of 20) AxisPosn=Magnet.vertex(73 of 80) WhichAxis=X
  coordinate_system FaceCS6 = face of Magnet_5: Origin=Magnet.vertex(60 of 80) FaceID=Magnet.face(15 of 20) AxisPosn=Magnet.vertex(57 of 80) WhichAxis=X
  coordinate_system FaceCS7 = face of Magnet_6: Origin=Magnet.vertex(71 of 80) FaceID=Magnet.face(18 of 20) AxisPosn=Magnet.vertex(70 of 80) WhichAxis=X
  coordinate_system FaceCS9 = face of Magnet_8: Origin=Magnet.vertex(52 of 80) FaceID=Magnet.face(13 of 20) AxisPosn=Magnet.vertex(49 of 80) WhichAxis=X
  coordinate_system FaceCS10 = face of Magnet_9: Origin=Magnet.vertex(26 of 80) FaceID=Magnet.face(7 of 20) AxisPosn=Magnet.vertex(27 of 80) WhichAxis=X
  coordinate_system FaceCS11 = face of Magnet_10: Origin=Magnet.vertex(79 of 80) FaceID=Magnet.face(20 of 20) AxisPosn=Magnet.vertex(78 of 80) WhichAxis=X
  coordinate_system FaceCS12 = face of Magnet_11: Origin=Magnet.vertex(21 of 80) FaceID=Magnet.face(6 of 20) AxisPosn=Magnet.vertex(24 of 80) WhichAxis=X
  coordinate_system FaceCS13 = face of Magnet_12: Origin=Magnet.vertex(47 of 80) FaceID=Magnet.face(12 of 20) AxisPosn=Magnet.vertex(46 of 80) WhichAxis=X
  coordinate_system FaceCS14 = face of Magnet_13: Origin=Magnet.vertex(68 of 80) FaceID=Magnet.face(17 of 20) AxisPosn=Magnet.vertex(65 of 80) WhichAxis=X
  coordinate_system FaceCS15 = face of Magnet_14: Origin=Magnet.vertex(13 of 80) FaceID=Magnet.face(4 of 20) AxisPosn=Magnet.vertex(16 of 80) WhichAxis=X
  coordinate_system FaceCS16 = face of Magnet_15: Origin=Magnet.vertex(18 of 80) FaceID=Magnet.face(5 of 20) AxisPosn=Magnet.vertex(19 of 80) WhichAxis=X
  coordinate_system FaceCS17 = face of Magnet_16: Origin=Magnet.vertex(55 of 80) FaceID=Magnet.face(14 of 20) AxisPosn=Magnet.vertex(54 of 80) WhichAxis=X
  coordinate_system FaceCS18 = face of Magnet_17: Origin=Magnet.vertex(10 of 80) FaceID=Magnet.face(3 of 20) AxisPosn=Magnet.vertex(11 of 80) WhichAxis=X
  coordinate_system FaceCS19 = face of Magnet_18: Origin=Magnet.vertex(33 of 80) FaceID=Magnet.face(9 of 20) AxisPosn=Magnet.vertex(36 of 80) WhichAxis=X
  coordinate_system FaceCS20 = face of Magnet_19: Origin=Magnet.vertex(44 of 80) FaceID=Magnet.face(11 of 20) AxisPosn=Magnet.vertex(41 of 80) WhichAxis=X
  coordinate_system FaceCS8 = face of Magnet_7: Origin=Magnet.vertex(63 of 80) FaceID=Magnet.face(16 of 20) AxisPosn=Magnet.vertex(62 of 80) WhichAxis=X
  PhaseA_Separate1 [copper] = PhaseA.separate_bodies()
  PhaseA_1_Separate1 [copper] = PhaseA_1.separate_bodies()
  PhaseA_2_Separate1 [copper] = PhaseA_2.separate_bodies()
  PhaseA_3_Separate1 [copper] = PhaseA_3.separate_bodies()
  PhaseA_4_Separate1 [copper] = PhaseA_4.separate_bodies()
  PhaseA_5_Separate1 [copper] = PhaseA_5.separate_bodies()
  PhaseA_6_Separate1 [copper] = PhaseA_6.separate_bodies()
  PhaseA_7_Separate1 [copper] = PhaseA_7.separate_bodies()
  PhaseA_8_Separate1 [copper] = PhaseA_8.separate_bodies()
  PhaseA_9_Separate1 [copper] = PhaseA_9.separate_bodies()
  PhaseB_Separate1 [copper] = PhaseB.separate_bodies()
  PhaseB_1_Separate1 [copper] = PhaseB_1.separate_bodies()
  PhaseB_2_Separate1 [copper] = PhaseB_2.separate_bodies()
  PhaseB_3_Separate1 [copper] = PhaseB_3.separate_bodies()
  PhaseB_4_Separate1 [copper] = PhaseB_4.separate_bodies()
  PhaseB_5_Separate1 [copper] = PhaseB_5.separate_bodies()
  PhaseB_6_Separate1 [copper] = PhaseB_6.separate_bodies()
  PhaseB_7_Separate1 [copper] = PhaseB_7.separate_bodies()
  PhaseB_8_Separate1 [copper] = PhaseB_8.separate_bodies()
  PhaseB_9_Separate1 [copper] = PhaseB_9.separate_bodies()
  PhaseC_Separate1 [copper] = PhaseC.separate_bodies()
  PhaseC_1_Separate1 [copper] = PhaseC_1.separate_bodies()
  PhaseC_2_Separate1 [copper] = PhaseC_2.separate_bodies()
  PhaseC_3_Separate1 [copper] = PhaseC_3.separate_bodies()
  PhaseC_4_Separate1 [copper] = PhaseC_4.separate_bodies()
  PhaseC_5_Separate1 [copper] = PhaseC_5.separate_bodies()
  PhaseC_6_Separate1 [copper] = PhaseC_6.separate_bodies()
  PhaseC_7_Separate1 [copper] = PhaseC_7.separate_bodies()
  PhaseC_8_Separate1 [copper] = PhaseC_8.separate_bodies()
  PhaseC_9_Separate1 [copper] = PhaseC_9.separate_bodies()
motion:
  MotionSetup1: Band Move_Type=Rotate Coordinate_System=Global Axis=Z Is_Positive=true InitPos=Thet_init Angular_Velocity=speed_rpm*pi/30 Objects=Band
  Moving1: Moving Objects=[Rotor, Band_in, Rotor2, Rotor3, Magnet, Magnet_3, Magnet_17, Magnet_14, Magnet_15, Magnet_11, Magnet_9, Magnet_1, Magnet_18, Magnet_2, Magnet_19, Magnet_12, Magnet_8, Magnet_16, Magnet_5, Magnet_7, Magnet_13, Magnet_6, Magnet_4, Magnet_10]
boundaries and excitations:
  Zero_Flux: Vector Potential Edges=Region.edge(1 of 1) Value=0
  PhaseA_9_Separate1: Coil Objects=PhaseA_9_Separate1 Conductor_number=num_turn Winding=Phase_A PolarityType=Positive
  PhaseA: Coil Objects=PhaseA Conductor_number=num_turn Winding=Phase_A PolarityType=Positive
  PhaseB_9_Separate1: Coil Objects=PhaseB_9_Separate1 Conductor_number=num_turn Winding=Phase_B PolarityType=Positive
  PhaseB: Coil Objects=PhaseB Conductor_number=num_turn Winding=Phase_B PolarityType=Positive
  PhaseC_Separate1: Coil Objects=PhaseC_Separate1 Conductor_number=num_turn Winding=Phase_C PolarityType=Positive
  PhaseC_1: Coil Objects=PhaseC_1 Conductor_number=num_turn Winding=Phase_C PolarityType=Positive
  PhaseA_1_Separate1: Coil Objects=PhaseA_1_Separate1 Conductor_number=num_turn Winding=Phase_A PolarityType=Positive
  PhaseA_2: Coil Objects=PhaseA_2 Conductor_number=num_turn Winding=Phase_A PolarityType=Positive
  PhaseB_1_Separate1: Coil Objects=PhaseB_1_Separate1 Conductor_number=num_turn Winding=Phase_B PolarityType=Positive
  PhaseB_2: Coil Objects=PhaseB_2 Conductor_number=num_turn Winding=Phase_B PolarityType=Positive
  PhaseC_2_Separate1: Coil Objects=PhaseC_2_Separate1 Conductor_number=num_turn Winding=Phase_C PolarityType=Positive
  PhaseC_3: Coil Objects=PhaseC_3 Conductor_number=num_turn Winding=Phase_C PolarityType=Positive
  PhaseA_3_Separate1: Coil Objects=PhaseA_3_Separate1 Conductor_number=num_turn Winding=Phase_A PolarityType=Positive
  PhaseA_4: Coil Objects=PhaseA_4 Conductor_number=num_turn Winding=Phase_A PolarityType=Positive
  PhaseB_3_Separate1: Coil Objects=PhaseB_3_Separate1 Conductor_number=num_turn Winding=Phase_B PolarityType=Positive
  PhaseB_4: Coil Objects=PhaseB_4 Conductor_number=num_turn Winding=Phase_B PolarityType=Positive
  PhaseC_4_Separate1: Coil Objects=PhaseC_4_Separate1 Conductor_number=num_turn Winding=Phase_C PolarityType=Positive
  PhaseC_5: Coil Objects=PhaseC_5 Conductor_number=num_turn Winding=Phase_C PolarityType=Positive
  PhaseA_5_Separate1: Coil Objects=PhaseA_5_Separate1 Conductor_number=num_turn Winding=Phase_A PolarityType=Positive
  PhaseA_6: Coil Objects=PhaseA_6 Conductor_number=num_turn Winding=Phase_A PolarityType=Positive
  PhaseB_5_Separate1: Coil Objects=PhaseB_5_Separate1 Conductor_number=num_turn Winding=Phase_B PolarityType=Positive
  PhaseB_6: Coil Objects=PhaseB_6 Conductor_number=num_turn Winding=Phase_B PolarityType=Positive
  PhaseC_6_Separate1: Coil Objects=PhaseC_6_Separate1 Conductor_number=num_turn Winding=Phase_C PolarityType=Positive
  PhaseC_7: Coil Objects=PhaseC_7 Conductor_number=num_turn Winding=Phase_C PolarityType=Positive
  PhaseA_7_Separate1: Coil Objects=PhaseA_7_Separate1 Conductor_number=num_turn Winding=Phase_A PolarityType=Positive
  PhaseA_8: Coil Objects=PhaseA_8 Conductor_number=num_turn Winding=Phase_A PolarityType=Positive
  PhaseB_7_Separate1: Coil Objects=PhaseB_7_Separate1 Conductor_number=num_turn Winding=Phase_B PolarityType=Positive
  PhaseB_8: Coil Objects=PhaseB_8 Conductor_number=num_turn Winding=Phase_B PolarityType=Positive
  PhaseC_8_Separate1: Coil Objects=PhaseC_8_Separate1 Conductor_number=num_turn Winding=Phase_C PolarityType=Positive
  PhaseC_9: Coil Objects=PhaseC_9 Conductor_number=num_turn Winding=Phase_C PolarityType=Positive
  PhaseC_9_Separate1: Coil Objects=PhaseC_9_Separate1 Conductor_number=num_turn Winding=Phase_C PolarityType=Negative
  PhaseC: Coil Objects=PhaseC Conductor_number=num_turn Winding=Phase_C PolarityType=Negative
  PhaseA_Separate1: Coil Objects=PhaseA_Separate1 Conductor_number=num_turn Winding=Phase_A PolarityType=Negative
  PhaseA_1: Coil Objects=PhaseA_1 Conductor_number=num_turn Winding=Phase_A PolarityType=Negative
  PhaseB_Separate1: Coil Objects=PhaseB_Separate1 Conductor_number=num_turn Winding=Phase_B PolarityType=Negative
  PhaseB_1: Coil Objects=PhaseB_1 Conductor_number=num_turn Winding=Phase_B PolarityType=Negative
  PhaseC_1_Separate1: Coil Objects=PhaseC_1_Separate1 Conductor_number=num_turn Winding=Phase_C PolarityType=Negative
  PhaseC_2: Coil Objects=PhaseC_2 Conductor_number=num_turn Winding=Phase_C PolarityType=Negative
  PhaseA_2_Separate1: Coil Objects=PhaseA_2_Separate1 Conductor_number=num_turn Winding=Phase_A PolarityType=Negative
  PhaseA_3: Coil Objects=PhaseA_3 Conductor_number=num_turn Winding=Phase_A PolarityType=Negative
  PhaseB_2_Separate1: Coil Objects=PhaseB_2_Separate1 Conductor_number=num_turn Winding=Phase_B PolarityType=Negative
  PhaseB_3: Coil Objects=PhaseB_3 Conductor_number=num_turn Winding=Phase_B PolarityType=Negative
  PhaseC_3_Separate1: Coil Objects=PhaseC_3_Separate1 Conductor_number=num_turn Winding=Phase_C PolarityType=Negative
  PhaseC_4: Coil Objects=PhaseC_4 Conductor_number=num_turn Winding=Phase_C PolarityType=Negative
  PhaseA_4_Separate1: Coil Objects=PhaseA_4_Separate1 Conductor_number=num_turn Winding=Phase_A PolarityType=Negative
  PhaseA_5: Coil Objects=PhaseA_5 Conductor_number=num_turn Winding=Phase_A PolarityType=Negative
  PhaseB_4_Separate1: Coil Objects=PhaseB_4_Separate1 Conductor_number=num_turn Winding=Phase_B PolarityType=Negative
  PhaseB_5: Coil Objects=PhaseB_5 Conductor_number=num_turn Winding=Phase_B PolarityType=Negative
  PhaseC_5_Separate1: Coil Objects=PhaseC_5_Separate1 Conductor_number=num_turn Winding=Phase_C PolarityType=Negative
  PhaseC_6: Coil Objects=PhaseC_6 Conductor_number=num_turn Winding=Phase_C PolarityType=Negative
  PhaseA_6_Separate1: Coil Objects=PhaseA_6_Separate1 Conductor_number=num_turn Winding=Phase_A PolarityType=Negative
  PhaseA_7: Coil Objects=PhaseA_7 Conductor_number=num_turn Winding=Phase_A PolarityType=Negative
  PhaseB_6_Separate1: Coil Objects=PhaseB_6_Separate1 Conductor_number=num_turn Winding=Phase_B PolarityType=Negative
  PhaseB_7: Coil Objects=PhaseB_7 Conductor_number=num_turn Winding=Phase_B PolarityType=Negative
  PhaseC_7_Separate1: Coil Objects=PhaseC_7_Separate1 Conductor_number=num_turn Winding=Phase_C PolarityType=Negative
  PhaseC_8: Coil Objects=PhaseC_8 Conductor_number=num_turn Winding=Phase_C PolarityType=Negative
  PhaseA_8_Separate1: Coil Objects=PhaseA_8_Separate1 Conductor_number=num_turn Winding=Phase_A PolarityType=Negative
  PhaseA_9: Coil Objects=PhaseA_9 Conductor_number=num_turn Winding=Phase_A PolarityType=Negative
  PhaseB_8_Separate1: Coil Objects=PhaseB_8_Separate1 Conductor_number=num_turn Winding=Phase_B PolarityType=Negative
  PhaseB_9: Coil Objects=PhaseB_9 Conductor_number=num_turn Winding=Phase_B PolarityType=Negative
  Phase_A: Winding Group Type=Current IsSolid=false Current=Imax*sin(Omega_rad*Time+Thet) ParallelBranchesNum=1
  Phase_B: Winding Group Type=Current IsSolid=false Current=Imax*sin(Omega_rad*Time-2*pi/3+Thet) ParallelBranchesNum=1
  Phase_C: Winding Group Type=Current IsSolid=false Current=Imax*sin(Omega_rad*Time+2*pi/3+Thet) ParallelBranchesNum=1
  core loss on: Stator, Rotor, Rotor2, Rotor3
mesh:
  Coils: LengthBased RefineInside Objects=[PhaseA, PhaseA_1..PhaseA_9, PhaseB, PhaseB_1..PhaseB_9, PhaseC, PhaseC_1..PhaseC_9] MaxLength=4mm
  RotorStator: LengthBased RefineInside Objects=[Rotor, Rotor2, Rotor3, Stator] MaxLength=4mm
  Length1: LengthBased RefineInside Objects=[Magnet, Magnet_1..Magnet_19] MaxLength=2mm
  initial mesh: MeshMethod=AnsoftTAU
setups:
  Setup1: Transient NonlinearSolverResidual=1e-06 SmoothBHCurve StopTime="(80/3) ms" TimeStep="(2/36) ms" SweepSetupType=LinearStep StartValue=0ns StopValue=8ms StepSize=0.8ms InitialTimeStep=0.002s MinTimeStep=0.001s MaxTimeStep=0.003s TimeStepErrTolerance=0.0001
field plots:
  Mag_B1: B over Rotor on Setup1 : Transient at Time=-1
reports:
  Torque Plot 1: Moving1.Torque vs Time on Setup1 : Transient
  Induced Voltages: InducedVoltage(Phase_A), InducedVoltage(Phase_B), InducedVoltage(Phase_C) vs Time on Setup1 : Transient
  Flux Linkages: FluxLinkage(Phase_A) vs Time on Setup1 : Transient; markers m1 at 4.0555556ms
   Plot 1: InputCurrent(Phase_A)*InducedVoltage(Phase_A) vs Time on Setup1 : Transient
